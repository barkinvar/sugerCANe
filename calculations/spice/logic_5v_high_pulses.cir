* logic_5v: actual Rev A divider, hysteresis and filter; typical TI model
.include lm2901_ngspice.lib
.model sensor_switch SW(Ron=10 Roff=1e12 Vt=.5 Vh=0)
Vbat vbat 0 12
Vlogic vlogic 0 3.3
Vstim stim 0 PWL(0.00000000 0 0.02000000 0 0.02000100 1 0.02025000 1 0.02025100 0 0.05025000 0 0.05025100 1 0.05075000 1 0.05075100 0 0.08075000 0 0.08075100 1 0.08150000 1 0.08150100 0 0.11150000 0 0.11150100 1 0.11250000 1 0.11250100 0 0.14250000 0 0.14250100 1 0.14375000 1 0.14375100 0 0.17375000 0 0.17375100 1 0.17525000 1 0.17525100 0 0.20525000 0 0.20525100 1 0.20700000 1 0.20700100 0 0.23700000 0 0.23700100 1 0.23880000 1 0.23880100 0 0.26880000 0 0.26880100 1 0.27065000 1 0.27065100 0 0.30065000 0 0.30065100 1 0.30255000 1 0.30255100 0 0.33255000 0 0.33255100 1 0.33450000 1 0.33450100 0 0.36450000 0 0.36450100 1 0.36650000 1 0.36650100 0 0.39650000 0 0.39650100 1 0.39855000 1 0.39855100 0 0.42855000 0 0.42855100 1 0.43065000 1 0.43065100 0 0.46065000 0 0.46065100 1 0.46280000 1 0.46280100 0 0.49280000 0 0.49280100 1 0.49500000 1 0.49500100 0 0.52500000 0 0.52500100 1 0.52725000 1 0.52725100 0 0.55725000 0 0.55725100 1 0.55955000 1 0.55955100 0 0.58955000 0 0.58955100 1 0.59190000 1 0.59190100 0 0.62190000 0 0.62190100 1 0.62430000 1 0.62430100 0 0.65430000 0 0.65430100 1 0.65675000 1 0.65675100 0 0.68675000 0 0.68675100 1 0.68925000 1 0.68925100 0 0.71925000 0 0.71925100 1 0.72180000 1 0.72180100 0 0.75180000 0 0.75180100 1 0.75440000 1 0.75440100 0 0.78440000 0 0.78440100 1 0.78705000 1 0.78705100 0 0.81705000 0 0.81705100 1 0.81975000 1 0.81975100 0 0.84975000 0 0.84975100 1 0.85250000 1 0.85250100 0 0.88250000 0 0.88250100 1 0.88530000 1 0.88530100 0 0.91530000 0 0.91530100 1 0.91815000 1 0.91815100 0 0.94815000 0 0.94815100 1 0.95105000 1 0.95105100 0 0.98105000 0 0.98105100 1 0.98400000 1 0.98400100 0 1.01400000 0 1.01400100 1 1.01700000 1 1.01700100 0 1.04700000 0 1.04700100 1 1.05005000 1 1.05005100 0 1.08005000 0 1.08005100 1 1.08315000 1 1.08315100 0 1.11315000 0 1.11315100 1 1.11630000 1 1.11630100 0 1.14630000 0 1.14630100 1 1.14950000 1 1.14950100 0 1.17950000 0 1.17950100 1 1.18275000 1 1.18275100 0 1.21275000 0 1.21275100 1 1.21625000 1 1.21625100 0 1.24625000 0 1.24625100 1 1.25000000 1 1.25000100 0 1.28000000 0 1.28000100 1 1.28400000 1 1.28400100 0 1.31400000 0 1.31400100 1 1.31825000 1 1.31825100 0 1.34825000 0 1.34825100 1 1.35275000 1 1.35275100 0 1.38275000 0 1.38275100 1 1.38750000 1 1.38750100 0 1.41750000 0 1.41750100 1 1.42250000 1 1.42250100 0 1.45250000 0 1.45250100 1 1.45775000 1 1.45775100 0 1.48775000 0 1.48775100 1 1.49325000 1 1.49325100 0 1.52325000 0 1.52325100 1 1.52900000 1 1.52900100 0 1.55900000 0 1.55900100 1 1.56500000 1 1.56500100 0 1.59500000 0 1.59500100 1 1.60125000 1 1.60125100 0 1.63125000 0 1.63125100 1 1.63775000 1 1.63775100 0 1.66775000 0 1.66775100 1 1.67450000 1 1.67450100 0 1.70450000 0 1.70450100 1 1.71150000 1 1.71150100 0 1.74150000 0 1.74150100 1 1.74875000 1 1.74875100 0 1.77875000 0 1.77875100 1 1.78625000 1 1.78625100 0 1.81625000 0 1.81625100 1 1.82400000 1 1.82400100 0 1.85400000 0 1.85400100 1 1.86200000 1 1.86200100 0 1.89200000 0 1.89200100 1 1.90025000 1 1.90025100 0 1.93025000 0 1.93025100 1 1.93875000 1 1.93875100 0 1.96875000 0 1.96875100 1 1.97750000 1 1.97750100 0 2.00750000 0 2.00750100 1 2.01650000 1 2.01650100 0 2.04650000 0 2.04650100 1 2.05575000 1 2.05575100 0 2.08575000 0 2.08575100 1 2.09525000 1 2.09525100 0 2.12525000 0 2.12525100 1 2.13500000 1 2.13500100 0 2.16500000 0 2.16500100 1 2.17500000 1 2.17500100 0 2.20500000 0 2.20500100 1 2.21525000 1 2.21525100 0 2.24525000 0 2.24525100 1 2.25575000 1 2.25575100 0 2.28575000 0 2.28575100 1 2.29650000 1 2.29650100 0 2.32650000 0 2.32650100 1 2.33750000 1 2.33750100 0 2.36750000 0 2.36750100 1 2.37875000 1 2.37875100 0 2.40875000 0 2.40875100 1 2.42025000 1 2.42025100 0 2.45025000 0 2.45025100 1 2.46200000 1 2.46200100 0 2.49200000 0 2.49200100 1 2.50400000 1 2.50400100 0 2.53400000 0 2.53400100 1 2.54625000 1 2.54625100 0 2.57625000 0 2.57625100 1 2.58875000 1 2.58875100 0 2.61875000 0 2.61875100 1 2.63150000 1 2.63150100 0 2.66150000 0 2.66150100 1 2.67450000 1 2.67450100 0 2.70450000 0 2.70450100 1 2.71775000 1 2.71775100 0 2.74775000 0 2.74775100 1 2.76125000 1 2.76125100 0 2.79125000 0 2.79125100 1 2.80500000 1 2.80500100 0 2.83500000 0 2.83500100 1 2.84900000 1 2.84900100 0 2.87900000 0 2.87900100 1 2.89325000 1 2.89325100 0 2.92325000 0 2.92325100 1 2.93775000 1 2.93775100 0 2.96775000 0 2.96775100 1 2.98250000 1 2.98250100 0 3.01250000 0 3.01250100 1 3.02750000 1 3.02750100 0 3.07750000 0)
Bsignal signal 0 V=5*v(stim)
R101 signal mid 110k
R102 mid sense 110k
R103 sense 0 20k
R104 sense output 910k
R105 output vlogic 10k
C101 sense 0 1n
R106 vlogic reference 100k
R107 reference 0 17.8k
R108 reference 0 7.15k
Xcomp sense reference vbat 0 output LM2901
.control
set wr_singlescale
set wr_vecnames
tran 5u 3.07750000
wrdata ../../reports/spice/pulse_work.txt v(output)
quit
.endc
.end
